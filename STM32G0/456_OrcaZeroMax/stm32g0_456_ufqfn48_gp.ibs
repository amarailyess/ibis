| IBIS file stm32g0_456_ufqfn48_gp.ibs
| Created by s2ibis version 1.1 (customized version)
| North Carolina State University, ERL, 2006
[IBIS ver] 4.2
[File name] stm32g0_456_ufqfn48_gp.ibs
[File Rev] 1.0
[Date]  03-08-2021
[Source] Data Created at STMicroelectronics
[Notes]  File originated from ELDO simulations.
[Disclaimer]  This information is for modeling purpose only and is
   not guaranted. The information is subject to change without
   notice.
[Copyright] Copyright 2013 STMicroelectronics Inc.
|   Component stm32g0_456_ufqfn48_gp
[Component] stm32g0_456_ufqfn48_gp
[Manufacturer] STMicroelectronics
[Package]
| variable   typ   min   max
R_pkg   0.0   0.0   0.0
L_pkg   0.0H   0.0H   0.0H
C_pkg   0.0F   0.0F   0.0F
[Pin]   signal_name   model_name  R_pin L_pin C_pin
1 PC13 io8_ft
2 PC14-OSC32_IN io8_ft
3 PC15-OSC32_OUT io8_ft
4 VBAT power
5 VREFP power
6 VDD power
7 VSS gnd
8 PF0-OSC_IN io6_ft
9 PF1-OSC_OUT io6_ft
10 PF2-NRST io6reset
11 PA0 io6_ft
12 PA1 io6_ft
13 PA2 io6_ft
14 PA3 io6_ft
15 PA4 io6_ft
16 PA5 io6_ft
17 PA6 io6_i2c_ft
18 PA7 io6_i2c_ft
19 PB0 io6_ft
20 PB1 io6_ft
21 PB2 io6_ft
22 PB10 io6_i2c_ft
23 PB11 io6_i2c_ft
24 PB12 io6_ft
25 PB13 io6_i2c_ft
26 PB14 io6_i2c_ft
27 PB15 io6usb_bmc_pd_cc_ft
28 PA8 io6usb_bmc_pd_cc_ft
29 PA9 io6_i2c_ft
30 PC6 io6_ft
31 PC7 io6_ft
32 PA10 io6_i2c_ft
33 PA11 io6usb
34 PA12 io6usb
35 PA13 io6_ft
36 PA14-BOOT0 io6_ft
37 PA15 io6_ft
38 PD0 io6usb_bmc_pd_cc_ft
39 PD1 io6_ft
40 PD2 io6usb_bmc_pd_cc_ft
41 PD3 io6_ft
42 PB3 io6_ft
43 PB4 io6_ft
44 PB5 io6_ft
45 PB6 io6_i2c_ft
46 PB7 io6_i2c_ft
47 PB8 io6_i2c_ft
48 PB9 io6_i2c_ft
[Model Selector] io6_ft
io6_ft_1v8_highspeed_pd  "GPIO-1.8V range - high speed - pull down"
io6_ft_1v8_fastspeed_pd  "GPIO-1.8V range - fast speed - pull down"
io6_ft_1v8_mediumspeed_pd  "GPIO-1.8V range - medium speed - pull down"
io6_ft_1v8_lowspeed_pd  "GPIO-1.8V range - low speed - pull down"
io6_ft_1v8_highspeed_pu  "GPIO-1.8V range - high speed - pull up"
io6_ft_1v8_fastspeed_pu  "GPIO-1.8V range - fast speed - pull up"
io6_ft_1v8_mediumspeed_pu  "GPIO-1.8V range - medium speed - pull up"
io6_ft_1v8_lowspeed_pu  "GPIO-1.8V range - low speed - pull up"
io6_ft_1v8_highspeed  "GPIO-1.8V range - high speed"
io6_ft_1v8_fastspeed  "GPIO-1.8V range - fast speed"
io6_ft_1v8_mediumspeed  "GPIO-1.8V range - medium speed"
io6_ft_1v8_lowspeed  "GPIO-1.8V range - low speed"
io6_ft_3v3_highspeed_pd  "GPIO-3.3V range - high speed - pull down"
io6_ft_3v3_fastspeed_pd  "GPIO-3.3V range - fast speed - pull down"
io6_ft_3v3_mediumspeed_pd  "GPIO-3.3V range - medium speed - pull down"
io6_ft_3v3_lowspeed_pd  "GPIO-3.3V range - low speed - pull down"
io6_ft_3v3_highspeed_pu  "GPIO-3.3V range - high speed - pull up"
io6_ft_3v3_fastspeed_pu  "GPIO-3.3V range - fast speed - pull up"
io6_ft_3v3_mediumspeed_pu  "GPIO-3.3V range - medium speed - pull up"
io6_ft_3v3_lowspeed_pu  "GPIO-3.3V range - low speed - pull up"
io6_ft_3v3_highspeed  "GPIO-3.3V range - high speed"
io6_ft_3v3_fastspeed  "GPIO-3.3V range - fast speed"
io6_ft_3v3_mediumspeed  "GPIO-3.3V range - medium speed"
io6_ft_3v3_lowspeed  "GPIO-3.3V range - low speed"
[Model Selector] io6_i2c_ft
io6_ft_1v8_highspeed_pd  "GPIO-1.8V range - high speed - pull down"
io6_ft_1v8_fastspeed_pd  "GPIO-1.8V range - fast speed - pull down"
io6_ft_1v8_mediumspeed_pd  "GPIO-1.8V range - medium speed - pull down"
io6_ft_1v8_lowspeed_pd  "GPIO-1.8V range - low speed - pull down"
io6_ft_1v8_highspeed_pu  "GPIO-1.8V range - high speed - pull up"
io6_ft_1v8_fastspeed_pu  "GPIO-1.8V range - fast speed - pull up"
io6_ft_1v8_mediumspeed_pu  "GPIO-1.8V range - medium speed - pull up"
io6_ft_1v8_lowspeed_pu  "GPIO-1.8V range - low speed - pull up"
io6_ft_1v8_highspeed  "GPIO-1.8V range - high speed"
io6_ft_1v8_fastspeed  "GPIO-1.8V range - fast speed"
io6_ft_1v8_mediumspeed  "GPIO-1.8V range - medium speed"
io6_ft_1v8_lowspeed  "GPIO-1.8V range - low speed"
io6_ft_3v3_highspeed_pd  "GPIO-3.3V range - high speed - pull down"
io6_ft_3v3_fastspeed_pd  "GPIO-3.3V range - fast speed - pull down"
io6_ft_3v3_mediumspeed_pd  "GPIO-3.3V range - medium speed - pull down"
io6_ft_3v3_lowspeed_pd  "GPIO-3.3V range - low speed - pull down"
io6_ft_3v3_highspeed_pu  "GPIO-3.3V range - high speed - pull up"
io6_ft_3v3_fastspeed_pu  "GPIO-3.3V range - fast speed - pull up"
io6_ft_3v3_mediumspeed_pu  "GPIO-3.3V range - medium speed - pull up"
io6_ft_3v3_lowspeed_pu  "GPIO-3.3V range - low speed - pull up"
io6_ft_3v3_highspeed  "GPIO-3.3V range - high speed"
io6_ft_3v3_fastspeed  "GPIO-3.3V range - fast speed"
io6_ft_3v3_mediumspeed  "GPIO-3.3V range - medium speed"
io6_ft_3v3_lowspeed  "GPIO-3.3V range - low speed"
io6_i2c_ft_1v8_pd  "GPIO-1.8V I2C functionality - pull down"
io6_i2c_ft_3v3_pd  "GPIO-3.3V I2C functionality - pull down"
io6_i2c_ft_1v8_pu  "GPIO-1.8V I2C functionality - pull up"
io6_i2c_ft_3v3_pu  "GPIO-3.3V I2C functionality pull up"
io6_i2c_ft_1v8  "GPIO-1.8V I2C functionality"
io6_i2c_ft_3v3  "GPIO-3.3V I2C functionality"
[Model Selector] io6usb
io6_ft_1v8_highspeed_pd  "GPIO-1.8V range - high speed - pull down"
io6_ft_1v8_fastspeed_pd  "GPIO-1.8V range - fast speed - pull down"
io6_ft_1v8_mediumspeed_pd  "GPIO-1.8V range - medium speed - pull down"
io6_ft_1v8_lowspeed_pd  "GPIO-1.8V range - low speed - pull down"
io6_ft_1v8_highspeed_pu  "GPIO-1.8V range - high speed - pull up"
io6_ft_1v8_fastspeed_pu  "GPIO-1.8V range - fast speed - pull up"
io6_ft_1v8_mediumspeed_pu  "GPIO-1.8V range - medium speed - pull up"
io6_ft_1v8_lowspeed_pu  "GPIO-1.8V range - low speed - pull up"
io6_ft_1v8_highspeed  "GPIO-1.8V range - high speed"
io6_ft_1v8_fastspeed  "GPIO-1.8V range - fast speed"
io6_ft_1v8_mediumspeed  "GPIO-1.8V range - medium speed"
io6_ft_1v8_lowspeed  "GPIO-1.8V range - low speed"
io6_ft_3v3_highspeed_pd  "GPIO-3.3V range - high speed - pull down"
io6_ft_3v3_fastspeed_pd  "GPIO-3.3V range - fast speed - pull down"
io6_ft_3v3_mediumspeed_pd  "GPIO-3.3V range - medium speed - pull down"
io6_ft_3v3_lowspeed_pd  "GPIO-3.3V range - low speed - pull down"
io6_ft_3v3_highspeed_pu  "GPIO-3.3V range - high speed - pull up"
io6_ft_3v3_fastspeed_pu  "GPIO-3.3V range - fast speed - pull up"
io6_ft_3v3_mediumspeed_pu  "GPIO-3.3V range - medium speed - pull up"
io6_ft_3v3_lowspeed_pu  "GPIO-3.3V range - low speed - pull up"
io6_ft_3v3_highspeed  "GPIO-3.3V range - high speed"
io6_ft_3v3_fastspeed  "GPIO-3.3V range - fast speed"
io6_ft_3v3_mediumspeed  "GPIO-3.3V range - medium speed"
io6_ft_3v3_lowspeed  "GPIO-3.3V range - low speed"
usb_ls_pd  "USB Low Speed mode - Pull Down"
usb_ls_pu2  "USB Low Speed mode - Pull up 2"
usb_ls_pu  "USB Low Speed mode - Pull up"
usb_fs  "USB Low Speed mode"
usb_fs_pd  "USB Full Speed mode - Pull Down"
usb_fs_pu2  "USB Full Speed mode - Pull up 2"
usb_fs_pu  "USB Full Speed mode - Pull up"
[Model Selector] io6reset
io6_ft_1v8_highspeed_pd  "GPIO-1.8V range - high speed - pull down"
io6_ft_1v8_fastspeed_pd  "GPIO-1.8V range - fast speed - pull down"
io6_ft_1v8_mediumspeed_pd  "GPIO-1.8V range - medium speed - pull down"
io6_ft_1v8_lowspeed_pd  "GPIO-1.8V range - low speed - pull down"
io6_ft_1v8_highspeed_pu  "GPIO-1.8V range - high speed - pull up"
io6_ft_1v8_fastspeed_pu  "GPIO-1.8V range - fast speed - pull up"
io6_ft_1v8_mediumspeed_pu  "GPIO-1.8V range - medium speed - pull up"
io6_ft_1v8_lowspeed_pu  "GPIO-1.8V range - low speed - pull up"
io6_ft_1v8_highspeed  "GPIO-1.8V range - high speed"
io6_ft_1v8_fastspeed  "GPIO-1.8V range - fast speed"
io6_ft_1v8_mediumspeed  "GPIO-1.8V range - medium speed"
io6_ft_1v8_lowspeed  "GPIO-1.8V range - low speed"
io6_ft_3v3_highspeed_pd  "GPIO-3.3V range - high speed - pull down"
io6_ft_3v3_fastspeed_pd  "GPIO-3.3V range - fast speed - pull down"
io6_ft_3v3_mediumspeed_pd  "GPIO-3.3V range - medium speed - pull down"
io6_ft_3v3_lowspeed_pd  "GPIO-3.3V range - low speed - pull down"
io6_ft_3v3_highspeed_pu  "GPIO-3.3V range - high speed - pull up"
io6_ft_3v3_fastspeed_pu  "GPIO-3.3V range - fast speed - pull up"
io6_ft_3v3_mediumspeed_pu  "GPIO-3.3V range - medium speed - pull up"
io6_ft_3v3_lowspeed_pu  "GPIO-3.3V range - low speed - pull up"
io6_ft_3v3_highspeed  "GPIO-3.3V range - high speed"
io6_ft_3v3_fastspeed  "GPIO-3.3V range - fast speed"
io6_ft_3v3_mediumspeed  "GPIO-3.3V range - medium speed"
io6_ft_3v3_lowspeed  "GPIO-3.3V range - low speed"
ioreset_1v2_pu  "RESET 1.2V range with PU"
ioreset_1v2  "RESET 1.2V range"
ioreset_1v8_pu  "RESET 1.8V range with PU"
ioreset_1v8  "RESET 1.8V range"
ioreset_3v3_pu  "RESET 3.3V range with PU"
ioreset_3v3  "RESET 3.3V range"
[Model Selector] io6usb_bmc_pd_cc_ft
usb_bmc_emit_pdccpd  "BMC PD emitter  + PD"
usb_bmc_emit_pdcc3a0  "BMC PD emitter  + 3rd PU"
usb_bmc_emit_pdcc1a5  "BMC PD emitter  + 2nd PU"
usb_bmc_emit_pdccusb  "BMC PD emitter  + 1st PU"
usb_bmc_emit  "BMC PD emitter "
io2_pdcc_ft_3v3_lowspeed  "GPIO-3.3V range - low speed"
io2_pdcc_ft_3v3_mediumspeed  "GPIO-3.3V range - medium speed"
io2_pdcc_ft_3v3_lowspeed_pu  "GPIO-3.3V range - low speed - pull up"
io2_pdcc_ft_3v3_mediumspeed_pu  "GPIO-3.3V range - medium speed - pull up"
io2_pdcc_ft_3v3_lowspeed_pd  "GPIO-3.3V range - low speed - pull down"
io2_pdcc_ft_3v3_mediumspeed_pd  "GPIO-3.3V range - medium speed - pull down"
io2_pdcc_ft_1v8_lowspeed  "GPIO-1.8V range - low speed"
io2_pdcc_ft_1v8_mediumspeed  "GPIO-1.8V range - medium speed"
io2_pdcc_ft_1v8_lowspeed_pu  "GPIO-1.8V range - low speed - pull up"
io2_pdcc_ft_1v8_mediumspeed_pu  "GPIO-1.8V range - medium speed - pull up"
io2_pdcc_ft_1v8_lowspeed_pd  "GPIO-1.8V range - low speed - pull down"
io2_pdcc_ft_1v8_mediumspeed_pd  "GPIO-1.8V range - medium speed - pull down"
io2_pdcc_ft_1v2_lowspeed  "GPIO-1.2V range - low speed"
io2_pdcc_ft_1v2_mediumspeed  "GPIO-1.2V range - medium speed"
io2_pdcc_ft_1v2_lowspeed_pu  "GPIO-1.2V range - low speed - pull up"
io2_pdcc_ft_1v2_mediumspeed_pu  "GPIO-1.2V range - medium speed - pull up"
io2_pdcc_ft_1v2_lowspeed_pd  "GPIO-1.2V range - low speed - pull down"
io2_pdcc_ft_1v2_mediumspeed_pd  "GPIO-1.2V range - medium speed - pull down"
[Model Selector] io8_ft
io8_ft_ls_1v2   "GPIO - 5V tolerant - 1.2V range - Low speed"
io8_ft_ms_1v2   "GPIO - 5V tolerant - 1.2V range - Med speed"
io8_ft_fs_1v2   "GPIO - 5V tolerant - 1.2V range - Fast speed"
io8_ft_hs_1v2   "GPIO - 5V tolerant - 1.2V range - High speed"
io8_ft_ls_1v8   "GPIO - 5V tolerant - 1.8V range - Low speed"
io8_ft_ms_1v8   "GPIO - 5V tolerant - 1.8V range - Med speed"
io8_ft_fs_1v8   "GPIO - 5V tolerant - 1.8V range - Fast speed"
io8_ft_hs_1v8   "GPIO - 5V tolerant - 1.8V range - High speed"
io8_ft_ls_3v3   "GPIO - 5V tolerant - 3.3V range - Low speed"
io8_ft_ms_3v3   "GPIO - 5V tolerant - 3.3V range - Med speed"
io8_ft_fs_3v3   "GPIO - 5V tolerant - 3.3V range - Fast speed"
io8_ft_hs_3v3   "GPIO - 5V tolerant - 3.3V range - High speed"
| Models and submodels in the file (78): io6_ft_1v8_highspeed_pd (I/O), io6_ft_1v8_fastspeed_pd (I/O), io6_ft_1v8_mediumspeed_pd (I/O), io6_ft_1v8_lowspeed_pd (I/O), io6_ft_1v8_highspeed_pu (I/O), io6_ft_1v8_fastspeed_pu (I/O), io6_ft_1v8_mediumspeed_pu (I/O), io6_ft_1v8_lowspeed_pu (I/O), io6_ft_1v8_highspeed (I/O), io6_ft_1v8_fastspeed (I/O), io6_ft_1v8_mediumspeed (I/O), io6_ft_1v8_lowspeed (I/O), io6_ft_3v3_highspeed_pd (I/O), io6_ft_3v3_fastspeed_pd (I/O), io6_ft_3v3_mediumspeed_pd (I/O), io6_ft_3v3_lowspeed_pd (I/O), io6_ft_3v3_highspeed_pu (I/O), io6_ft_3v3_fastspeed_pu (I/O), io6_ft_3v3_mediumspeed_pu (I/O), io6_ft_3v3_lowspeed_pu (I/O), io6_ft_3v3_highspeed (I/O), io6_ft_3v3_fastspeed (I/O), io6_ft_3v3_mediumspeed (I/O), io6_ft_3v3_lowspeed (I/O), io6_i2c_ft_1v8_pd (I/O_open_drain), io6_i2c_ft_3v3_pd (I/O_open_drain), io6_i2c_ft_1v8_pu (I/O_open_drain), io6_i2c_ft_3v3_pu (I/O_open_drain), io6_i2c_ft_1v8 (I/O_open_drain), io6_i2c_ft_3v3 (I/O_open_drain), usb_ls_pd (I/O), usb_ls_pu2 (I/O), usb_ls_pu (I/O), usb_fs (I/O), usb_fs_pd (I/O), usb_fs_pu2 (I/O), usb_fs_pu (I/O), ioreset_1v2_pu (I/O_open_drain), ioreset_1v2 (I/O_open_drain), ioreset_1v8_pu (I/O_open_drain), ioreset_1v8 (I/O_open_drain), ioreset_3v3_pu (I/O_open_drain), ioreset_3v3 (I/O_open_drain), usb_bmc_emit_pdccpd (I/O), usb_bmc_emit_pdcc3a0 (I/O), usb_bmc_emit_pdcc1a5 (I/O), usb_bmc_emit_pdccusb (I/O), usb_bmc_emit (I/O), io2_pdcc_ft_3v3_lowspeed (I/O), io2_pdcc_ft_3v3_mediumspeed (I/O), io2_pdcc_ft_3v3_lowspeed_pu (I/O), io2_pdcc_ft_3v3_mediumspeed_pu (I/O), io2_pdcc_ft_3v3_lowspeed_pd (I/O), io2_pdcc_ft_3v3_mediumspeed_pd (I/O), io2_pdcc_ft_1v8_lowspeed (I/O), io2_pdcc_ft_1v8_mediumspeed (I/O), io2_pdcc_ft_1v8_lowspeed_pu (I/O), io2_pdcc_ft_1v8_mediumspeed_pu (I/O), io2_pdcc_ft_1v8_lowspeed_pd (I/O), io2_pdcc_ft_1v8_mediumspeed_pd (I/O), io2_pdcc_ft_1v2_lowspeed (I/O), io2_pdcc_ft_1v2_mediumspeed (I/O), io2_pdcc_ft_1v2_lowspeed_pu (I/O), io2_pdcc_ft_1v2_mediumspeed_pu (I/O), io2_pdcc_ft_1v2_lowspeed_pd (I/O), io2_pdcc_ft_1v2_mediumspeed_pd (I/O), io8_ft_ls_1v2 (I/O), io8_ft_ms_1v2 (I/O), io8_ft_fs_1v2 (I/O), io8_ft_hs_1v2 (I/O), io8_ft_ls_1v8 (I/O), io8_ft_ms_1v8 (I/O), io8_ft_fs_1v8 (I/O), io8_ft_hs_1v8 (I/O), io8_ft_ls_3v3 (I/O), io8_ft_ms_3v3 (I/O), io8_ft_fs_3v3 (I/O), io8_ft_hs_3v3 (I/O)
