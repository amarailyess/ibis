| IBIS file stm32g0_467_lqfp32noio2.ibs
| Created by s2ibis version 1.1 (customized version)
| North Carolina State University, ERL, 2006
[IBIS ver] 4.2
[File name] stm32g0_467_lqfp32noio2.ibs
[File Rev] rev1.0
[Date]  09-11-2022
[Source] Data Created at STMicroelectronics
[Notes]  File originated from ELDO simulations.
[Disclaimer]  This information is for modeling purpose only and is
   not guaranted. The information is subject to change without
   notice.
[Copyright] Copyright 2013 STMicroelectronics Inc.
|   Component stm32g0_467_lqfp32noio2
[Component] stm32g0_467_lqfp32noio2
[Manufacturer] STMicroelectronics
[Package]
| variable   typ   min   max
R_pkg   0.0   0.0   0.0
L_pkg   0.0H   0.0H   0.0H
C_pkg   0.0F   0.0F   0.0F
[Pin]   signal_name   model_name  R_pin L_pin C_pin
1 PB9 io6_i2c_ft 64.896E-3 2.0240E-9 16.235E-15
2 PC14 io8prog2m25m50m120m_sudq_ft 54.988E-3 1.7405E-9 14.587E-15
3 PC15 io8prog2m25m50m120m_sudq_ft 53.017E-3 1.6595E-9 8.197E-15
4 VDD power 54.033E-3 1.6554E-9 7.363E-15
5 VSS gnd 56.223E-3 1.7156E-9 10.783E-15
6 PF2 io6reset 61.160E-3 1.8629E-9 10.243E-15
7 PA0 io6_ft 59.987E-3 1.8648E-9 10.852E-15
8 PA1 io6_ft 71.192E-3 2.1932E-9 17.019E-15
9 PA2 io6_ft 71.059E-3 2.1776E-9 16.855E-15
10 PA3 io6_ft 63.005E-3 1.9478E-9 14.439E-15
11 PA4 io6_ft 58.243E-3 1.7981E-9 7.948E-15
12 PA5 io6_ft 55.874E-3 1.7092E-9 8.812E-15
13 PA6 io6_ft 55.141E-3 1.6964E-9 12.212E-15
14 PA7 io6_i2c_ft 56.661E-3 1.7554E-9 4.706E-15
15 PB0 io6_ft 61.182E-3 1.8979E-9 13.557E-15
16 PB1 io6_ft 68.639E-3 2.1172E-9 16.500E-15
17 PB15 io6usb_bmc_pd_cc_ft 66.539E-3 2.0692E-9 17.677E-15
18 PA8 io6usb_bmc_pd_cc_ft 71.158E-3 2.1438E-9 11.062E-15
19 PA9 io6_i2c_ft 63.842E-3 1.9327E-9 9.196E-15
20 PC6 io6_ft 58.291E-3 1.7635E-9 11.677E-15
21 PA10 io6_i2c_ft 54.700E-3 1.6700E-9 6.891E-15
22 PA11 io6usb 53.046E-3 1.6525E-9 10.905E-15
23 PA12 io6usb 62.866E-3 1.9450E-9 11.111E-15
24 PA13 io6_ft 75.711E-3 2.3060E-9 17.278E-15
25 PA14 io6_ft 74.224E-3 2.2583E-9 19.736E-15
26 PD0 io6usb_bmc_pd_cc_ft 65.224E-3 2.0006E-9 8.439E-15
27 PD1 io6_ft 59.281E-3 1.8183E-9 10.281E-15
28 PD2 io6usb_bmc_pd_cc_ft 56.029E-3 1.7169E-9 8.461E-15
29 PD3 io6_ft 55.139E-3 1.6969E-9 12.383E-15
30 PB6 io6_i2c_ft 56.372E-3 1.7463E-9 4.202E-15
31 PB7 io6_i2c_ft 59.845E-3 1.8672E-9 13.676E-15
32 PB8 io6_i2c_ft 66.777E-3 2.0705E-9 14.725E-15
[Model Selector] io8prog2m25m50m120m_sudq_ft
iols8p_sudq_ft_pd_lv  "IO low speed, PD=40kOhm - 1P8V"
iols8p_sudq_ft_pu_lv  "IO low speed, PU=40kOhm - 1P8V"
iols8p_sudq_ft_lv  "IO low speed - 1P8V"
iols8p_sudq_ft_pd  "IO low speed, PD=40kOhm - 3P3V"
iols8p_sudq_ft_pu  "IO low speed, PU=40kOhm - 3P3V"
iols8p_sudq_ft  "IO low speed - 3P3V"
iofs8p_sudq_ft_pd_lv  "IO full speed, PD=40kOhm - 1P8V"
iofs8p_sudq_ft_pu_lv  "IO full speed, PU=40kOhm - 1P8V"
iofs8p_sudq_ft_lv  "IO full speed - 1P8V"
iofs8p_sudq_ft_pd  "IO full speed, PD=40kOhm - 3P3V"
iofs8p_sudq_ft_pu  "IO full speed, PU=40kOhm - 3P3V"
iofs8p_sudq_ft  "IO full speed - 3P3V"
ioms8p_sudq_ft_pd_lv  "IO medium speed, PD=40kOhm - 1P8V"
ioms8p_sudq_ft_pu_lv  "IO medium speed, PU=40kOhm - 1P8V"
ioms8p_sudq_ft_lv  "IO medium speed - 1P8V"
ioms8p_sudq_ft_pd  "IO medium speed, PD=40kOhm - 3P3V"
ioms8p_sudq_ft_pu  "IO medium speed, PU=40kOhm - 3P3V"
ioms8p_sudq_ft  "IO medium speed - 3P3V"
iohs8p_sudq_ft_pd_lv  "IO high speed, PD=40kOhm - 1P8V"
iohs8p_sudq_ft_pu_lv  "IO high speed, PU=40kOhm - 1P8V"
iohs8p_sudq_ft_lv  "IO high speed - 1P8V"
iohs8p_sudq_ft_pd  "IO high speed, PD=40kOhm - 3P3V"
iohs8p_sudq_ft_pu  "IO high speed, PU=40kOhm - 3P3V"
iohs8p_sudq_ft  "IO high speed - 3P3V"
[Model Selector] io6_ft
io6_ft_1v8_highspeed_pd  "GPIO-1.8V range - high speed - pull down"
io6_ft_1v8_fastspeed_pd  "GPIO-1.8V range - fast speed - pull down"
io6_ft_1v8_mediumspeed_pd  "GPIO-1.8V range - medium speed - pull down"
io6_ft_1v8_lowspeed_pd  "GPIO-1.8V range - low speed - pull down"
io6_ft_1v8_highspeed_pu  "GPIO-1.8V range - high speed - pull up"
io6_ft_1v8_fastspeed_pu  "GPIO-1.8V range - fast speed - pull up"
io6_ft_1v8_mediumspeed_pu  "GPIO-1.8V range - medium speed - pull up"
io6_ft_1v8_lowspeed_pu  "GPIO-1.8V range - low speed - pull up"
io6_ft_1v8_highspeed  "GPIO-1.8V range - high speed"
io6_ft_1v8_fastspeed  "GPIO-1.8V range - fast speed"
io6_ft_1v8_mediumspeed  "GPIO-1.8V range - medium speed"
io6_ft_1v8_lowspeed  "GPIO-1.8V range - low speed"
io6_ft_3v3_highspeed_pd  "GPIO-3.3V range - high speed - pull down"
io6_ft_3v3_fastspeed_pd  "GPIO-3.3V range - fast speed - pull down"
io6_ft_3v3_mediumspeed_pd  "GPIO-3.3V range - medium speed - pull down"
io6_ft_3v3_lowspeed_pd  "GPIO-3.3V range - low speed - pull down"
io6_ft_3v3_highspeed_pu  "GPIO-3.3V range - high speed - pull up"
io6_ft_3v3_fastspeed_pu  "GPIO-3.3V range - fast speed - pull up"
io6_ft_3v3_mediumspeed_pu  "GPIO-3.3V range - medium speed - pull up"
io6_ft_3v3_lowspeed_pu  "GPIO-3.3V range - low speed - pull up"
io6_ft_3v3_highspeed  "GPIO-3.3V range - high speed"
io6_ft_3v3_fastspeed  "GPIO-3.3V range - fast speed"
io6_ft_3v3_mediumspeed  "GPIO-3.3V range - medium speed"
io6_ft_3v3_lowspeed  "GPIO-3.3V range - low speed"
[Model Selector] io6_i2c_ft
io6_ft_1v8_highspeed_pd  "GPIO-1.8V range - high speed - pull down"
io6_ft_1v8_fastspeed_pd  "GPIO-1.8V range - fast speed - pull down"
io6_ft_1v8_mediumspeed_pd  "GPIO-1.8V range - medium speed - pull down"
io6_ft_1v8_lowspeed_pd  "GPIO-1.8V range - low speed - pull down"
io6_ft_1v8_highspeed_pu  "GPIO-1.8V range - high speed - pull up"
io6_ft_1v8_fastspeed_pu  "GPIO-1.8V range - fast speed - pull up"
io6_ft_1v8_mediumspeed_pu  "GPIO-1.8V range - medium speed - pull up"
io6_ft_1v8_lowspeed_pu  "GPIO-1.8V range - low speed - pull up"
io6_ft_1v8_highspeed  "GPIO-1.8V range - high speed"
io6_ft_1v8_fastspeed  "GPIO-1.8V range - fast speed"
io6_ft_1v8_mediumspeed  "GPIO-1.8V range - medium speed"
io6_ft_1v8_lowspeed  "GPIO-1.8V range - low speed"
io6_ft_3v3_highspeed_pd  "GPIO-3.3V range - high speed - pull down"
io6_ft_3v3_fastspeed_pd  "GPIO-3.3V range - fast speed - pull down"
io6_ft_3v3_mediumspeed_pd  "GPIO-3.3V range - medium speed - pull down"
io6_ft_3v3_lowspeed_pd  "GPIO-3.3V range - low speed - pull down"
io6_ft_3v3_highspeed_pu  "GPIO-3.3V range - high speed - pull up"
io6_ft_3v3_fastspeed_pu  "GPIO-3.3V range - fast speed - pull up"
io6_ft_3v3_mediumspeed_pu  "GPIO-3.3V range - medium speed - pull up"
io6_ft_3v3_lowspeed_pu  "GPIO-3.3V range - low speed - pull up"
io6_ft_3v3_highspeed  "GPIO-3.3V range - high speed"
io6_ft_3v3_fastspeed  "GPIO-3.3V range - fast speed"
io6_ft_3v3_mediumspeed  "GPIO-3.3V range - medium speed"
io6_ft_3v3_lowspeed  "GPIO-3.3V range - low speed"
io6_ft_1v8_highi2c_pd   "GPIO-1.8V range - high   speed i2c mode - pd"
io6_ft_1v8_fasti2c_pd   "GPIO-1.8V range - fast   speed i2c mode - pd"
io6_ft_1v8_mediumi2c_pd  "GPIO-1.8V range - medium speed i2c mode - pd"
io6_ft_1v8_lowi2c_pd   "GPIO-1.8V range - low   speed i2c mode - pd"
io6_ft_1v8_highi2c_pu   "GPIO-1.8V range - high   speed i2c mode - pu"
io6_ft_1v8_fasti2c_pu   "GPIO-1.8V range - fast   speed i2c mode - pu"
io6_ft_1v8_mediumi2c_pu  "GPIO-1.8V range - medium speed i2c mode - pu"
io6_ft_1v8_lowi2c_pu   "GPIO-1.8V range - low   speed i2c mode - pu"
io6_ft_1v8_highi2c   "GPIO-1.8V range - high   speed i2c mode"
io6_ft_1v8_fasti2c   "GPIO-1.8V range - fast   speed i2c mode"
io6_ft_1v8_mediumi2c   "GPIO-1.8V range - medium speed i2c mode"
io6_ft_1v8_lowi2c   "GPIO-1.8V range - low   speed i2c mode"
io6_ft_3v3_highi2c_pd   "GPIO-3.3V range - high   speed i2c mode - pd"
io6_ft_3v3_fasti2c_pd   "GPIO-3.3V range - fast   speed i2c mode - pd"
io6_ft_3v3_mediumi2c_pd  "GPIO-3.3V range - medium speed i2c mode - pd"
io6_ft_3v3_lowi2c_pd   "GPIO-3.3V range - low   speed i2c mode - pd"
io6_ft_3v3_highi2c_pu   "GPIO-3.3V range - high   speed i2c mode - pu"
io6_ft_3v3_fasti2c_pu   "GPIO-3.3V range - fast   speed i2c mode - pu"
io6_ft_3v3_mediumi2c_pu  "GPIO-3.3V range - medium speed i2c mode - pu"
io6_ft_3v3_lowi2c_pu   "GPIO-3.3V range - low   speed i2c mode - pu"
io6_ft_3v3_highi2c   "GPIO-3.3V range - high   speed i2c mode"
io6_ft_3v3_fasti2c   "GPIO-3.3V range - fast   speed i2c mode"
io6_ft_3v3_mediumi2c   "GPIO-3.3V range - medium speed i2c mode"
io6_ft_3v3_lowi2c   "GPIO-3.3V range - low   speed i2c mode"
io6_i2c_ft_1v8_pd  "GPIO-1.8V I2C fm+ - pd"
io6_i2c_ft_3v3_pd  "GPIO-3.3V I2C fm+ - pd"
io6_i2c_ft_1v8_pu  "GPIO-1.8V I2C fm+ - pu"
io6_i2c_ft_3v3_pu  "GPIO-3.3V I2C fm+ - pu"
io6_i2c_ft_1v8   "GPIO-1.8V I2C fm+"
io6_i2c_ft_3v3   "GPIO-3.3V I2C fm+"
[Model Selector] io6usb
io6_ft_1v8_highspeed_pd  "GPIO-1.8V range - high speed - pull down"
io6_ft_1v8_fastspeed_pd  "GPIO-1.8V range - fast speed - pull down"
io6_ft_1v8_mediumspeed_pd  "GPIO-1.8V range - medium speed - pull down"
io6_ft_1v8_lowspeed_pd  "GPIO-1.8V range - low speed - pull down"
io6_ft_1v8_highspeed_pu  "GPIO-1.8V range - high speed - pull up"
io6_ft_1v8_fastspeed_pu  "GPIO-1.8V range - fast speed - pull up"
io6_ft_1v8_mediumspeed_pu  "GPIO-1.8V range - medium speed - pull up"
io6_ft_1v8_lowspeed_pu  "GPIO-1.8V range - low speed - pull up"
io6_ft_1v8_highspeed  "GPIO-1.8V range - high speed"
io6_ft_1v8_fastspeed  "GPIO-1.8V range - fast speed"
io6_ft_1v8_mediumspeed  "GPIO-1.8V range - medium speed"
io6_ft_1v8_lowspeed  "GPIO-1.8V range - low speed"
io6_ft_3v3_highspeed_pd  "GPIO-3.3V range - high speed - pull down"
io6_ft_3v3_fastspeed_pd  "GPIO-3.3V range - fast speed - pull down"
io6_ft_3v3_mediumspeed_pd  "GPIO-3.3V range - medium speed - pull down"
io6_ft_3v3_lowspeed_pd  "GPIO-3.3V range - low speed - pull down"
io6_ft_3v3_highspeed_pu  "GPIO-3.3V range - high speed - pull up"
io6_ft_3v3_fastspeed_pu  "GPIO-3.3V range - fast speed - pull up"
io6_ft_3v3_mediumspeed_pu  "GPIO-3.3V range - medium speed - pull up"
io6_ft_3v3_lowspeed_pu  "GPIO-3.3V range - low speed - pull up"
io6_ft_3v3_highspeed  "GPIO-3.3V range - high speed"
io6_ft_3v3_fastspeed  "GPIO-3.3V range - fast speed"
io6_ft_3v3_mediumspeed  "GPIO-3.3V range - medium speed"
io6_ft_3v3_lowspeed  "GPIO-3.3V range - low speed"
usb_ls_pd  "USB Low Speed mode - Pull Down"
usb_ls_pu2  "USB Low Speed mode - Pull up 2"
usb_ls_pu  "USB Low Speed mode - Pull up"
usb_fs  "USB Low Speed mode"
usb_fs_pd  "USB Full Speed mode - Pull Down"
usb_fs_pu2  "USB Full Speed mode - Pull up 2"
usb_fs_pu  "USB Full Speed mode - Pull up"
[Model Selector] io6reset
io6_ft_1v8_highspeed_pd  "GPIO-1.8V range - high speed - pull down"
io6_ft_1v8_fastspeed_pd  "GPIO-1.8V range - fast speed - pull down"
io6_ft_1v8_mediumspeed_pd  "GPIO-1.8V range - medium speed - pull down"
io6_ft_1v8_lowspeed_pd  "GPIO-1.8V range - low speed - pull down"
io6_ft_1v8_highspeed_pu  "GPIO-1.8V range - high speed - pull up"
io6_ft_1v8_fastspeed_pu  "GPIO-1.8V range - fast speed - pull up"
io6_ft_1v8_mediumspeed_pu  "GPIO-1.8V range - medium speed - pull up"
io6_ft_1v8_lowspeed_pu  "GPIO-1.8V range - low speed - pull up"
io6_ft_1v8_highspeed  "GPIO-1.8V range - high speed"
io6_ft_1v8_fastspeed  "GPIO-1.8V range - fast speed"
io6_ft_1v8_mediumspeed  "GPIO-1.8V range - medium speed"
io6_ft_1v8_lowspeed  "GPIO-1.8V range - low speed"
io6_ft_3v3_highspeed_pd  "GPIO-3.3V range - high speed - pull down"
io6_ft_3v3_fastspeed_pd  "GPIO-3.3V range - fast speed - pull down"
io6_ft_3v3_mediumspeed_pd  "GPIO-3.3V range - medium speed - pull down"
io6_ft_3v3_lowspeed_pd  "GPIO-3.3V range - low speed - pull down"
io6_ft_3v3_highspeed_pu  "GPIO-3.3V range - high speed - pull up"
io6_ft_3v3_fastspeed_pu  "GPIO-3.3V range - fast speed - pull up"
io6_ft_3v3_mediumspeed_pu  "GPIO-3.3V range - medium speed - pull up"
io6_ft_3v3_lowspeed_pu  "GPIO-3.3V range - low speed - pull up"
io6_ft_3v3_highspeed  "GPIO-3.3V range - high speed"
io6_ft_3v3_fastspeed  "GPIO-3.3V range - fast speed"
io6_ft_3v3_mediumspeed  "GPIO-3.3V range - medium speed"
io6_ft_3v3_lowspeed  "GPIO-3.3V range - low speed"
ioreset_1v2_pu  "RESET 1.2V range with PU"
ioreset_1v2  "RESET 1.2V range"
ioreset_1v8_pu  "RESET 1.8V range with PU"
ioreset_1v8  "RESET 1.8V range"
ioreset_3v3_pu  "RESET 3.3V range with PU"
ioreset_3v3  "RESET 3.3V range"
[Model Selector] io6usb_bmc_pd_cc_ft
usb_bmc_emit_pdccpd  "BMC PD emitter  + PD"
usb_bmc_emit_pdcc3a0  "BMC PD emitter  + 3rd PU"
usb_bmc_emit_pdcc1a5  "BMC PD emitter  + 2nd PU"
usb_bmc_emit_pdccusb  "BMC PD emitter  + 1st PU"
usb_bmc_emit  "BMC PD emitter "
io2_pdcc_ft_3v3_lowspeed  "GPIO-3.3V range - low speed"
io2_pdcc_ft_3v3_mediumspeed  "GPIO-3.3V range - medium speed"
io2_pdcc_ft_3v3_lowspeed_pu  "GPIO-3.3V range - low speed - pull up"
io2_pdcc_ft_3v3_mediumspeed_pu  "GPIO-3.3V range - medium speed - pull up"
io2_pdcc_ft_3v3_lowspeed_pd  "GPIO-3.3V range - low speed - pull down"
io2_pdcc_ft_3v3_mediumspeed_pd  "GPIO-3.3V range - medium speed - pull down"
io2_pdcc_ft_1v8_lowspeed  "GPIO-1.8V range - low speed"
io2_pdcc_ft_1v8_mediumspeed  "GPIO-1.8V range - medium speed"
io2_pdcc_ft_1v8_lowspeed_pu  "GPIO-1.8V range - low speed - pull up"
io2_pdcc_ft_1v8_mediumspeed_pu  "GPIO-1.8V range - medium speed - pull up"
io2_pdcc_ft_1v8_lowspeed_pd  "GPIO-1.8V range - low speed - pull down"
io2_pdcc_ft_1v8_mediumspeed_pd  "GPIO-1.8V range - medium speed - pull down"
io2_pdcc_ft_1v2_lowspeed  "GPIO-1.2V range - low speed"
io2_pdcc_ft_1v2_mediumspeed  "GPIO-1.2V range - medium speed"
io2_pdcc_ft_1v2_lowspeed_pu  "GPIO-1.2V range - low speed - pull up"
io2_pdcc_ft_1v2_mediumspeed_pu  "GPIO-1.2V range - medium speed - pull up"
io2_pdcc_ft_1v2_lowspeed_pd  "GPIO-1.2V range - low speed - pull down"
io2_pdcc_ft_1v2_mediumspeed_pd  "GPIO-1.2V range - medium speed - pull down"
| Models and submodels in the file (114): iols8p_sudq_ft_pd_lv (I/O), iols8p_sudq_ft_pu_lv (I/O), iols8p_sudq_ft_lv (I/O), iols8p_sudq_ft_pd (I/O), iols8p_sudq_ft_pu (I/O), iols8p_sudq_ft (I/O), iofs8p_sudq_ft_pd_lv (I/O), iofs8p_sudq_ft_pu_lv (I/O), iofs8p_sudq_ft_lv (I/O), iofs8p_sudq_ft_pd (I/O), iofs8p_sudq_ft_pu (I/O), iofs8p_sudq_ft (I/O), ioms8p_sudq_ft_pd_lv (I/O), ioms8p_sudq_ft_pu_lv (I/O), ioms8p_sudq_ft_lv (I/O), ioms8p_sudq_ft_pd (I/O), ioms8p_sudq_ft_pu (I/O), ioms8p_sudq_ft (I/O), iohs8p_sudq_ft_pd_lv (I/O), iohs8p_sudq_ft_pu_lv (I/O), iohs8p_sudq_ft_lv (I/O), iohs8p_sudq_ft_pd (I/O), iohs8p_sudq_ft_pu (I/O), iohs8p_sudq_ft (I/O), io6_ft_1v8_highspeed_pd (I/O), io6_ft_1v8_fastspeed_pd (I/O), io6_ft_1v8_mediumspeed_pd (I/O), io6_ft_1v8_lowspeed_pd (I/O), io6_ft_1v8_highspeed_pu (I/O), io6_ft_1v8_fastspeed_pu (I/O), io6_ft_1v8_mediumspeed_pu (I/O), io6_ft_1v8_lowspeed_pu (I/O), io6_ft_1v8_highspeed (I/O), io6_ft_1v8_fastspeed (I/O), io6_ft_1v8_mediumspeed (I/O), io6_ft_1v8_lowspeed (I/O), io6_ft_3v3_highspeed_pd (I/O), io6_ft_3v3_fastspeed_pd (I/O), io6_ft_3v3_mediumspeed_pd (I/O), io6_ft_3v3_lowspeed_pd (I/O), io6_ft_3v3_highspeed_pu (I/O), io6_ft_3v3_fastspeed_pu (I/O), io6_ft_3v3_mediumspeed_pu (I/O), io6_ft_3v3_lowspeed_pu (I/O), io6_ft_3v3_highspeed (I/O), io6_ft_3v3_fastspeed (I/O), io6_ft_3v3_mediumspeed (I/O), io6_ft_3v3_lowspeed (I/O), io6_i2c_ft_1v8_pd (I/O_open_drain), io6_i2c_ft_3v3_pd (I/O_open_drain), io6_i2c_ft_1v8_pu (I/O_open_drain), io6_i2c_ft_3v3_pu (I/O_open_drain), io6_i2c_ft_1v8 (I/O_open_drain), io6_i2c_ft_3v3 (I/O_open_drain), io6_ft_1v8_highi2c_pd (I/O_open_drain), io6_ft_1v8_fasti2c_pd (I/O_open_drain), io6_ft_1v8_mediumi2c_pd (I/O_open_drain), io6_ft_1v8_lowi2c_pd (I/O_open_drain), io6_ft_1v8_highi2c_pu (I/O_open_drain), io6_ft_1v8_fasti2c_pu (I/O_open_drain), io6_ft_1v8_mediumi2c_pu (I/O_open_drain), io6_ft_1v8_lowi2c_pu (I/O_open_drain), io6_ft_1v8_highi2c (I/O_open_drain), io6_ft_1v8_fasti2c (I/O_open_drain), io6_ft_1v8_mediumi2c (I/O_open_drain), io6_ft_1v8_lowi2c (I/O_open_drain), io6_ft_3v3_highi2c_pd (I/O_open_drain), io6_ft_3v3_fasti2c_pd (I/O_open_drain), io6_ft_3v3_mediumi2c_pd (I/O_open_drain), io6_ft_3v3_lowi2c_pd (I/O_open_drain), io6_ft_3v3_highi2c_pu (I/O_open_drain), io6_ft_3v3_fasti2c_pu (I/O_open_drain), io6_ft_3v3_mediumi2c_pu (I/O_open_drain), io6_ft_3v3_lowi2c_pu (I/O_open_drain), io6_ft_3v3_highi2c (I/O_open_drain), io6_ft_3v3_fasti2c (I/O_open_drain), io6_ft_3v3_mediumi2c (I/O_open_drain), io6_ft_3v3_lowi2c (I/O_open_drain), usb_ls_pd (I/O), usb_ls_pu2 (I/O)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
