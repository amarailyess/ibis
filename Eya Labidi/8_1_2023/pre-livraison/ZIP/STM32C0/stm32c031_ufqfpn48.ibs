| IBIS file stm32c0_ufqfpn48.ibs
| Created by s2ibis version 1.1 (customized version)
| North Carolina State University, ERL, 2006
[IBIS ver] 4.2
[File name] stm32c0_ufqfpn48.ibs
[File Rev] 1.1
[Date]  08-08-2022
[Source] Data Created at STMicroelectronics
[Notes]  File originated from ELDO simulations.
[Disclaimer]  This information is for modeling purpose only and is
   not guaranted. The information is subject to change without
   notice.
[Copyright] Copyright 2013 STMicroelectronics Inc.
|   Component stm32c0_ufqfpn48
[Component] stm32c0_ufqfpn48
[Manufacturer] STMicroelectronics
[Package]
| variable   typ   min   max
R_pkg  0  NA  NA
L_pkg  0  NA  NA
C_pkg  0  NA  NA
[Pin]   signal_name   model_name
| pin 0 is Exposed Pad
0  VSS  gnd
1  PC13  io8prog2m25m50m120m_sudq_ft
2  PC14  io8prog2m25m50m120m_sudq_i2c_ft
3  PC15  io8prog2m25m50m120m_sudq_ft
4  PF3  io8prog2m25m50m120m_sudq_ft
5  VREFP  nc
6  VDD  power
7  VSS  gnd
8  PF0  io8prog2m25m50m120m_sudq_ft
9  PF1  io8prog2m25m50m120m_sudq_ft
10  PF2  ioreset_ft_v33
11  PA0  io8prog2m25m50m120m_sudq_ft
12  PA1  io8prog2m25m50m120m_sudq_ft
13  PA2  io8prog2m25m50m120m_sudq_ft
14  PA3  io8prog2m25m50m120m_sudq_ft
15  PA4  io8prog2m25m50m120m_sudq_ft
16  PA5  io8prog2m25m50m120m_sudq_ft
17  PA6  io8prog2m25m50m120m_sudq_ft
18  PA7  io8prog2m25m50m120m_sudq_ft
19  PB0  io8prog2m25m50m120m_sudq_ft
20  PB1  io8prog2m25m50m120m_sudq_ft
21  PB2  io8prog2m25m50m120m_sudq_ft
22  PB10  io8prog2m25m50m120m_sudq_ft
23  PB11  io8prog2m25m50m120m_sudq_ft
24  PB12  io8prog2m25m50m120m_sudq_ft
25  PB13  io8prog2m25m50m120m_sudq_ft
26  PB14  io8prog2m25m50m120m_sudq_ft
27  PB15  io8prog2m25m50m120m_sudq_ft
28  PA8  io8prog2m25m50m120m_sudq_ft
29  PA9  io8prog2m25m50m120m_sudq_i2c_ft
30  PC6  io8prog2m25m50m120m_sudq_ft
31  PC7  io8prog2m25m50m120m_sudq_ft
32  PA10  io8prog2m25m50m120m_sudq_i2c_ft
33  PA11  io8prog2m25m50m120m_sudq_i2c_ft
34  PA12  io8prog2m25m50m120m_sudq_i2c_ft
35  PA13  io8prog2m25m50m120m_sudq_ft
36  PA14  io8prog2m25m50m120m_sudq_ft
37  PA15  io8prog2m25m50m120m_sudq_ft
38  PD0  io8prog2m25m50m120m_sudq_ft
39  PD1  io8prog2m25m50m120m_sudq_ft
40  PD2  io8prog2m25m50m120m_sudq_ft
41  PD3  io8prog2m25m50m120m_sudq_ft
42  PB3  io8prog2m25m50m120m_sudq_ft
43  PB4  io8prog2m25m50m120m_sudq_ft
44  PB5  io8prog2m25m50m120m_sudq_i2c_ft
45  PB6  io8prog2m25m50m120m_sudq_i2c_ft
46  PB7  io8prog2m25m50m120m_sudq_i2c_ft
47  PB8  io8prog2m25m50m120m_sudq_i2c_ft
48  PB9  io8prog2m25m50m120m_sudq_i2c_ft
[Package Model]   453-ufqfpn-7x7-48l-220510
[Pin Mapping]   pulldown_ref   pullup_ref   | Comment
0  gndio  nc
1  gndio  vddiom
2  gndio  vddiom
3  gndio  vddiom
4  gndio  vddiom
5  nc  nc
6  nc  vddiom
7  gndio  nc
8  gndio  vddiom
9  gndio  vddiom
10  gndio  vddiom
11  gndio  vddiom
12  gndio  vddiom
13  gndio  vddiom
14  gndio  vddiom
15  gndio  vddiom
16  gndio  vddiom
17  gndio  vddiom
18  gndio  vddiom
19  gndio  vddiom
20  gndio  vddiom
21  gndio  vddiom
22  gndio  vddiom
23  gndio  vddiom
24  gndio  vddiom
25  gndio  vddiom
26  gndio  vddiom
27  gndio  vddiom
28  gndio  vddiom
29  gndio  vddiom
30  gndio  vddiom
31  gndio  vddiom
32  gndio  vddiom
33  gndio  vddiom
34  gndio  vddiom
35  gndio  vddiom
36  gndio  vddiom
37  gndio  vddiom
38  gndio  vddiom
39  gndio  vddiom
40  gndio  vddiom
41  gndio  vddiom
42  gndio  vddiom
43  gndio  vddiom
44  gndio  vddiom
45  gndio  vddiom
46  gndio  vddiom
47  gndio  vddiom
48  gndio  vddiom
[Model Selector] io8prog2m25m50m120m_sudq_ft
iols8p_sudq_ft_pd_lv  "IO low speed, PD=40kOhm - 1P8V"
iols8p_sudq_ft_pu_lv  "IO low speed, PU=40kOhm - 1P8V"
iols8p_sudq_ft_lv  "IO low speed - 1P8V"
iols8p_sudq_ft_pd  "IO low speed, PD=40kOhm - 3P3V"
iols8p_sudq_ft_pu  "IO low speed, PU=40kOhm - 3P3V"
iols8p_sudq_ft  "IO low speed - 3P3V"
iofs8p_sudq_ft_pd_lv  "IO full speed, PD=40kOhm - 1P8V"
iofs8p_sudq_ft_pu_lv  "IO full speed, PU=40kOhm - 1P8V"
iofs8p_sudq_ft_lv  "IO full speed - 1P8V"
iofs8p_sudq_ft_pd  "IO full speed, PD=40kOhm - 3P3V"
iofs8p_sudq_ft_pu  "IO full speed, PU=40kOhm - 3P3V"
iofs8p_sudq_ft  "IO full speed - 3P3V"
ioms8p_sudq_ft_pd_lv  "IO medium speed, PD=40kOhm - 1P8V"
ioms8p_sudq_ft_pu_lv  "IO medium speed, PU=40kOhm - 1P8V"
ioms8p_sudq_ft_lv  "IO medium speed - 1P8V"
ioms8p_sudq_ft_pd  "IO medium speed, PD=40kOhm - 3P3V"
ioms8p_sudq_ft_pu  "IO medium speed, PU=40kOhm - 3P3V"
ioms8p_sudq_ft  "IO medium speed - 3P3V"
iohs8p_sudq_ft_pd_lv  "IO high speed, PD=40kOhm - 1P8V"
iohs8p_sudq_ft_pu_lv  "IO high speed, PU=40kOhm - 1P8V"
iohs8p_sudq_ft_lv  "IO high speed - 1P8V"
iohs8p_sudq_ft_pd  "IO high speed, PD=40kOhm - 3P3V"
iohs8p_sudq_ft_pu  "IO high speed, PU=40kOhm - 3P3V"
iohs8p_sudq_ft  "IO high speed - 3P3V"
[Model Selector] io8prog2m25m50m120m_sudq_i2c_ft
io8prog_1v8_i2c_pd  "5V Tol GPIO 1.8V range i2c functionality with pull down"
io8prog_1v8_i2c_pu  "5V Tol GPIO 1.8V range i2c functionality with pull up"
io8prog_1v8_i2c  "5V Tol GPIO 1.8V range i2c functionality"
io8prog_3v3_i2c_pd  "5V Tol GPIO 3.3V range i2c functionality with pull down"
io8prog_3v3_i2c_pu  "5V Tol GPIO 3.3V range i2c functionality with pull up"
io8prog_3v3_i2c  "5V Tol GPIO 3.3V range i2c functionality"
iols8p_sudq_ft_pd_lv  "IO low speed, PD=40kOhm - 1P8V"
iols8p_sudq_ft_pu_lv  "IO low speed, PU=40kOhm - 1P8V"
iols8p_sudq_ft_lv  "IO low speed - 1P8V"
iols8p_sudq_ft_pd  "IO low speed, PD=40kOhm - 3P3V"
iols8p_sudq_ft_pu  "IO low speed, PU=40kOhm - 3P3V"
iols8p_sudq_ft  "IO low speed - 3P3V"
iofs8p_sudq_ft_pd_lv  "IO full speed, PD=40kOhm - 1P8V"
iofs8p_sudq_ft_pu_lv  "IO full speed, PU=40kOhm - 1P8V"
iofs8p_sudq_ft_lv  "IO full speed - 1P8V"
iofs8p_sudq_ft_pd  "IO full speed, PD=40kOhm - 3P3V"
iofs8p_sudq_ft_pu  "IO full speed, PU=40kOhm - 3P3V"
iofs8p_sudq_ft  "IO full speed - 3P3V"
ioms8p_sudq_ft_pd_lv  "IO medium speed, PD=40kOhm - 1P8V"
ioms8p_sudq_ft_pu_lv  "IO medium speed, PU=40kOhm - 1P8V"
ioms8p_sudq_ft_lv  "IO medium speed - 1P8V"
ioms8p_sudq_ft_pd  "IO medium speed, PD=40kOhm - 3P3V"
ioms8p_sudq_ft_pu  "IO medium speed, PU=40kOhm - 3P3V"
ioms8p_sudq_ft  "IO medium speed - 3P3V"
iohs8p_sudq_ft_pd_lv  "IO high speed, PD=40kOhm - 1P8V"
iohs8p_sudq_ft_pu_lv  "IO high speed, PU=40kOhm - 1P8V"
iohs8p_sudq_ft_lv  "IO high speed - 1P8V"
iohs8p_sudq_ft_pd  "IO high speed, PD=40kOhm - 3P3V"
iohs8p_sudq_ft_pu  "IO high speed, PU=40kOhm - 3P3V"
iohs8p_sudq_ft  "IO high speed - 3P3V"
[Model Selector] ioreset_ft_v33
ioreset_1v2_pu  "RESET 1.2V range with PU"
ioreset_1v2  "RESET 1.2V range"
ioreset_1v8_pu  "RESET 1.8V range with PU"
ioreset_1v8  "RESET 1.8V range"
ioreset_3v3_pu  "RESET 3.3V range with PU"
ioreset_3v3  "RESET 3.3V range"
[Define Package Model]  453-ufqfpn-7x7-48l-220510
[Manufacturer]  Unknown
[OEM]  Unknown
[Description]  None
[Number Of Pins]  48
[Pin Numbers]
| Pin Num   Terminal Name
11 | PA0
32 | PA10
33 | PA11
34 | PA12
35 | PA13
36 | PA14
37 | PA15
12 | PA1
13 | PA2
14 | PA3
15 | PA4
16 | PA5
17 | PA6
18 | PA7
28 | PA8
29 | PA9
19 | PB0
22 | PB10
23 | PB11
24 | PB12
25 | PB13
26 | PB14
27 | PB15
20 | PB1
21 | PB2
42 | PB3
43 | PB4
44 | PB5
45 | PB6
46 | PB7
47 | PB8
48 | PB9
1 | PC13
2 | PC14
3 | PC15
30 | PC6
31 | PC7
38 | PD0
39 | PD1
40 | PD2
41 | PD3
8 | PF0
9 | PF1
10 | PF2
4 | PF3
6 | VDD
5 | VREFP
0 | VSS
|[Merged Pins]  0
|7  |  VSS
[Model Data]
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[End Model Data]
[End Package Model]
| Models and submodels in the file (36): iols8p_sudq_ft_pd_lv (I/O), iols8p_sudq_ft_pu_lv (I/O), iols8p_sudq_ft_lv (I/O), iols8p_sudq_ft_pd (I/O), iols8p_sudq_ft_pu (I/O), iols8p_sudq_ft (I/O), iofs8p_sudq_ft_pd_lv (I/O), iofs8p_sudq_ft_pu_lv (I/O), iofs8p_sudq_ft_lv (I/O), iofs8p_sudq_ft_pd (I/O), iofs8p_sudq_ft_pu (I/O), iofs8p_sudq_ft (I/O), ioms8p_sudq_ft_pd_lv (I/O), ioms8p_sudq_ft_pu_lv (I/O), ioms8p_sudq_ft_lv (I/O), ioms8p_sudq_ft_pd (I/O), ioms8p_sudq_ft_pu (I/O), ioms8p_sudq_ft (I/O), iohs8p_sudq_ft_pd_lv (I/O), iohs8p_sudq_ft_pu_lv (I/O), iohs8p_sudq_ft_lv (I/O), iohs8p_sudq_ft_pd (I/O), iohs8p_sudq_ft_pu (I/O), iohs8p_sudq_ft (I/O), io8prog_1v8_i2c_pd (I/O_open_drain), io8prog_1v8_i2c_pu (I/O_open_drain), io8prog_1v8_i2c (I/O_open_drain), io8prog_3v3_i2c_pd (I/O_open_drain), io8prog_3v3_i2c_pu (I/O_open_drain), io8prog_3v3_i2c (I/O_open_drain), ioreset_1v2_pu (I/O_open_drain), ioreset_1v2 (I/O_open_drain), ioreset_1v8_pu (I/O_open_drain), ioreset_1v8 (I/O_open_drain), ioreset_3v3_pu (I/O_open_drain), ioreset_3v3 (I/O_open_drain)
